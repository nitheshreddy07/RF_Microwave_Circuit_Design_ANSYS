# Ansys Electronics Desktop project, version 2022.2
materials:
  vacuum: permittivity=1

design HFSSDesign1 (HFSS, DrivenModal, model units mm)
variables:
  a = 22.86mm
  b = 10.16mm
  lw = 60mm
geometry:
  Box1 [vacuum] = box(corner=(0mm, 0mm, 0mm), size=(lw, a, b))
boundaries and excitations:
  PerfE1: Perfect E Faces=Box1.face(+z, -y, +y, -z)
  1: Wave Port Faces=Box1.face(+x) NumModes=4 Modes{Mode1{IntLine{(60, 11.43, 0) -> (60, 11.43, 10.16)} CharImp=Zpi} Mode2{IntLine{(60, 11.43, 0) -> (60, 11.43, 10.16)} CharImp=Zpi} Mode3{IntLine{(60, 11.43, 0) -> (60, 11.43, 10.16)} CharImp=Zpi} Mode4{IntLine{(60, 11.43, 0) -> (60, 11.43, 10.16)} CharImp=Zpi}}
  2: Wave Port Faces=Box1.face(-x) NumModes=4 Modes{Mode1{IntLine{(0, 11.43, 0) -> (0, 11.43, 10.16)} CharImp=Zpi} Mode2{IntLine{(0, 11.43, 0) -> (0, 11.43, 10.16)} CharImp=Zpi} Mode3{IntLine{(0, 11.43, 0) -> (0, 11.43, 10.16)} CharImp=Zpi} Mode4{IntLine{(0, 11.43, 0) -> (0, 11.43, 10.16)} CharImp=Zpi}}
setups:
  Setup1: HfssDriven MultipleAdaptiveFreqsSetup{Low=5GHz High=20GHz} MaxDeltaS=0.02 MaximumPasses=20 MinimumPasses=1 MinimumConvergedPasses=1 PercentRefinement=30 BasisOrder=1 PortAccuracy=2 DrivenSolverType="Direct Solver"
    sweep Sweep: 5GHz to 20GHz step 0.01GHz; Type=Fast SaveFields
source amplitudes:
  1:1, 1:2, 1:3, 2:1..2:4: 0W 0deg
  1:4: 1W 0deg
field plots:
  Mag_E1, Vector_E1: E Field in Box1 on Setup1 : Sweep at Freq=19.5GHz Phase=0deg
  Mag_H1, Vector_H1: H Field in Box1 on Setup1 : Sweep at Freq=19.5GHz Phase=0deg
reports:
  S Parameter Plot 1: dB(S(2:1,1:1)), dB(S(2:2,1:2)), dB(S(2:3,1:3)), dB(S(2:4,1:4)) vs Freq on Setup1 : Sweep
